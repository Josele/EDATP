ADE simulation setup
Run mode: Single Run, Sweeps and Corners
Tests:
  EDATP:FA_1bit_tb:1: EDATP/FA_1bit_tb/schematic, simulator spectre
    Outputs: A; B; Ci; Co; S
Global variables:
  Tp = 4n
  Wn = 440n
  Wp = Wn*1.7
  Vdd = 1.8
  Tsim = Tp*4
  Ap = 1
  B = 1
