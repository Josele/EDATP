ADE simulation setup
Run mode: Single Run, Sweeps and Corners
Tests:
  EDATP:NAND_tb:1: EDATP/NAND_tb/schematic, simulator spectre
    Outputs: NAND_A; NAND_B; NAND_O
