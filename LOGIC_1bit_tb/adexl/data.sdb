ADE simulation setup
Run mode: Single Run, Sweeps and Corners
Tests:
  EDATP:LOGIC_1bit_tb:1: EDATP/LOGIC_1bit_tb/schematic, simulator spectre
    Outputs: Logic_A; TpHL_B; TpLL_A_real; tr_O; tp_B; tp_B_real
Global variables:
  Tp = 4n
  Wn = 440n
  Wp = 440n
  VDD = 1.8
  Bp = 1
  Ba = 1
  Bn = 1
Specs:
  EDATP:LOGIC_1bit_tb:1 / TpHL_B: < 2n
  EDATP:LOGIC_1bit_tb:1 / tp_B: < 2n
  EDATP:LOGIC_1bit_tb:1 / tr_O: < 2n
  EDATP:LOGIC_1bit_tb:1 / tpLH_A: < 2n
