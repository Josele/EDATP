ADE simulation setup
Run mode: Single Run, Sweeps and Corners
Tests:
  EDATP:ALU_8bit_tb:1: EDATP/ALU_8bit_tb/schematic, simulator spectre
    Outputs: tp_A0_HL; tp_A0_LH; Fix_B; CTR<0>; CTR<1>; tp_A1_LH; tp_A1_HL
Global variables:
  Tp = 4n
  Vdd = 1.8
  Tsim = Tp*8
