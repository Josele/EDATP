ADE simulation setup
Run mode: Single Run, Sweeps and Corners
Tests:
  DC_Test (off): EDATP/MUX_4_1_8bit_TB/schematic, simulator spectre
    Outputs: INV_out
  Tran_Test: EDATP/MUX_4_1_8bit_TB/schematic, simulator spectre
    Outputs: MUX_out; A_in; B_in; C_in; D_in; S0_in; S1_in; A_Delay_F; delay(?wf1 VT("/A<0>") ?value1 0.9 ?edge1 "rising" ?nth1 25 ?td1 0.0 ?wf2 VT("/Q_out<0>") ?value2 0.9 ?edge2 "raising" ?nth2 1 ?td2 0.0 ?stop nil ?multiple nil); A_Delay_R; B_Delay_F; D_Delay_F; C_Delay_R
Global variables:
  VDD = 1.8
  Period = 4n
  Vsweep = 0
  Tsim = 32*Period
  Wp = 6u
  Wn = 3u
Specs:
  Tran_Test / D_Delay_R: < 400p
  Tran_Test / C_Delay_F: < 400p
  Tran_Test / B_Delay_R: < 400p
  Tran_Test / A_Delay_F: < 400p
  Tran_Test / D_Delay_F: < 400p
  Tran_Test / C_Delay_R: < 400p
  Tran_Test / B_Delay_F: < 400p
  Tran_Test / A_Delay_R: < 400p
