ADE simulation setup
Run mode: Single Run, Sweeps and Corners
Tests:
  EDATP:FA_8bit_tb:1: EDATP/FA_8bit_tb/schematic, simulator spectre
    Outputs: A0; S7; A1
Global variables:
  Tsim = Tp*4
  Tp = 3n
  Vdd = 1.8
  Wn = 180*2.4n
  Wp = Wn
